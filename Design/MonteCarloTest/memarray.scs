simulator lang=spectre

subckt memarray ( bl_1 bl_ref sel1_1 sel1_2 sel1_3 sel2_1 sel2_2 sel2_3 wl_1 wl_2 wl_3 vdd vss bp bn)

// mem cell branch
xSel1_1 node1_1 sel1_1 vdd bp mc_pmos_lvt w=PWmin l=PLmin
rLoad_1 (node1_1 bl_1) resistor r=Rload1

rMemcell (bl_1 node2_1) resistor r=Rmemcell
xSl_1 node2_1 wl_1 vss bn  mc_nmos_lvt w=PWmin l=PLmin

cLoad_1 (bl_1 gnd) capacitor c=Cload1
xSel2_1 bl_1 sel2_1 vss bn mc_nmos_lvt w=PWmin l=PLmin

// high ref cell branch
xSel1_2 node1_2 sel1_2 vdd bp mc_pmos_lvt w=PWmin l=PLmin
rLoad_2 (node1_2 bl_ref) resistor r=Rload2

rMemhigh (bl_ref node2_2) resistor r=Rmemhigh
xSl_2 node2_2 wl_2 vss bn mc_nmos_lvt w=PWmin l=PLmin

cLoad_2 (bl_ref gnd) capacitor c=Cload2
xSel2_2 bl_ref sel2_2 vss bn mc_nmos_lvt w=PWmin l=PLmin

// low ref cell branch
xXel1_3 node1_3 sel1_3 vdd bp mc_pmos_lvt w=PWmin l=PLmin
rLoad_3 (node1_3 bl_ref) resistor r=Rload3

rMemlow (bl_ref node2_3) resistor r=Rmemlow
xSl_3 node2_3 wl_3 vss bn mc_nmos_lvt w=PWmin l=PLmin

cLoad_3 (bl_ref gnd) capacitor c=Cload3
xSel2_3 bl_ref sel2_3 vss bn mc_nmos_lvt w=PWmin l=PLmin

ic bl_1=bl_1initial
ic bl_ref=bl_refinitial

ends memarray
