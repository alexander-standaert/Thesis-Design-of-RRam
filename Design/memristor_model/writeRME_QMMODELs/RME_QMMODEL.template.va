@@information

// ------------------------------------------------------------------------------------------------
// RME_QMMODEL : transient verilog model for RME
// - Implements QM conduction model [ Robin Degraeve + Philippe Roussel's Mathematica results ]
// - Implements basic set / reset / (form) behavior -- not necessary the correct behavior though!
// - For details: see PTW Oct 2011 presentation ( 201110_R104_Stefan_final.pptx )
//
// Author: Stefan Cosemans
// ------------------------------------------------------------------------------------------------

`include "disciplines.vams"
`include "constants.vams"

module @@modelName ( t1, t2, log10_omega_y );
inout t1, t2, log10_omega_y;
electrical t1, t2;

// ANALOG NODES {{{1
// ========================================================================

// Internal cell state:
electrical log10_omega_y; // omega_y. Stored as log10 to avoid convergence issues

// Set : make adjustment of omega_y towards Vhold smooth rather than all or nothing
electrical theta        ;
electrical doSet_node   ;

// Debug signals : include cell status and important information in the simulation waveforms
//
// note: must scale the parameters to reasonable values because simulator tries to converge
//       on those values as well, and abstol doesn't seem to work properly
// --------------------------------------------------
electrical log10_reset_T_per_decade; // [TODO: switch to use only log10_reset_T_per_decade]
electrical cellFormed_node;
electrical set_trigger_counter_node;
electrical log10_set_trigger_T;
electrical log10_omega_y_target;
// }}}1

// SPICE INSTANCE PARAMETERS {{{1
// ========================================================================

// initial cell state parameters
@@ifAnalytical  parameter real    initial_V0      = 0.0;
@@ifAnalytical  parameter real    initial_omega_x = 0.0;
@@ifAnalytical  parameter integer Nmax    = 100; //number of terms used to calculate RME current
parameter real    initial_omega_y = 0.0;
parameter real    initialFormed   = 0.0;

// parameters to describe reset depth afo Vapplied
parameter real reset_depth_Vreset_0  = 0;
parameter real reset_depth_omega_y_0 = 0; // omega_y value after resetting at reset_depth_Vreset_0
parameter real reset_depth_Vreset_1  = 0;
parameter real reset_depth_omega_y_1 = 0;

// parameters to describe reset tau afo Vapplied
parameter real reset_speed_V_0 = 0;
parameter real reset_speed_T_0 = 0;       // reset time constant (time per decade) when Vapplied = reset_speed_V_0
parameter real reset_speed_V_1 = 0;
parameter real reset_speed_T_1 = 0;       // NOTICE: changed from time per exp(1) to time per decade on 2011-11-07

// no reset above this voltage
parameter real reset_upper_bound_V = 0;   // do not perform reset if Vapplied > this value

// parameters to describe set_trigger_T afo Vapplied
parameter real set_speed_V_0 = 0;
parameter real set_speed_T_0 = 0;         // time (T) to set trigger when Vapplied = set_speed_V_0
parameter real set_speed_V_1 = 0;         // NOTICE: T = time per decade
parameter real set_speed_T_1 = 0;

// parameters to describe set operation
parameter real set_hold_V       = 0;      // during set, R_rme_during_set reduces until Vrme=set_hold_V
parameter real set_start_power  = 0;      // set counter starts when Irme*Vrme is larger than this value
parameter real set_eps_V        = 0;      // If Vrme <= set_hold_V-set_eps_V, cell exits special set mode
                                          //   make it slightly larger than 0 to avoid issues due to simulation accuracy
                                          // With a physical model, this probably shouldn't be an issue any more
parameter real set_T_per_decade = 1e-15;  // When the rme is in "special set mode", omega_y reduces with
                                          // 10x during 1 set_T_per_decade, e.g. 1e-9 = 1ns / decade

// forming voltage
parameter real form_V        =  0;

// cheat parameters for debug
parameter integer only_QM_IV           = 0;      // set to 1 to not change omega_y (disable set/reset)
parameter integer saveStateSignals     = 1;      // save omega_y, time constants etc
parameter integer writeLogFile         = 1;      // write a log file for this RME
parameter real    progressPrintStep    = 10e-9;  // output progress when this time is exceeded
parameter integer doBoundTimeStep      = 0;      // 0: do not bound timestep ; 1=do bound timestep
parameter real    timestep_normal      = 10e-12; // never allow larger timesteps between two transitions
parameter real    timestep_programming = 1e-12;  // use smaller timesteps when things change

// additional parameters
parameter real    capacitance      = 0.0;

// }}}1

// INTERNAL VARIABLE DECLARATION {{{1
// ========================================================================

// cell state
real    cellFormed;
@@ifAnalytical  real    V0        ;
@@ifAnalytical  real    omega_x   ;
real    omega_y   ;  // for convenience: it is set to 10^( V(log10_omega_y) )

real    Irme ; // for convenience: I( t1, t2 )
real    Vrme ; // for convenience: V( t1, t2 )

// reset
real    omega_y_target     ;
real    reset_T_per_decade ;
integer doReset;

// set
integer in_special_set_mode;
real    set_trigger_counter;
real    set_trigger_T      ; // notice: T per decade
real    set_smoothing_V    ; // smooth transition in doSet from 0 to 1 in Vhold ... Vhold + set_smoothing_V

// simulation stepsize and logging
real    prevTime  ; // time when this "function" was last called
real    timeStep  ; // time passed since previous evaluation
integer file      ; // write output for debugging. Set to 0 to suppress output
real    lastPrintedProgressPoint;

// simulation timestep control parameters (should not be used! Hence: put doBoundTimeStep to 0)
integer firstStep;

// }}}1

// INCLUDE FILES {{{1
// ----------------------------------------------------------------------
`include "../helperFunctions.v"
`include "../analyticalModel.v"
/// }}}1

// start actual code
// ----------------------------------------------------------------------
analog begin

// initial step {{{1
// ========================================================================
@( initial_step) begin

   // initialize cell
   cellFormed = initialFormed;
   omega_y = initial_omega_y;
@@ifAnalytical   omega_x = initial_omega_x;
@@ifAnalytical   V0      = initial_V0;

   // variables for reset
   omega_y_target      = 1;   // [need to put something, value is not used]
                              // notice: we can't use 0  --> issue with log10
   reset_T_per_decade  = 1e9; // [need to put something, value is not used]

   // variables for set
   set_smoothing_V     = 1e-3;
   set_trigger_T       = 1e9; // [value not used]
   set_trigger_counter = 0  ; // [value not used]
   in_special_set_mode = 0  ; // must be 0

   // debug and logging {{{2
   prevTime                 = 0;
   lastPrintedProgressPoint = 0;
   firstStep=1;

//   file = $fopen( "logs/log_%m.log" );   // set to "file=0" 0 to disable logging altogether
                                           // warning: spectre can only open 1024 files !

   file = $fopen( "logs/all_RMEs.log" );   // set to "file=0" 0 to disable logging altogether
   $fdisplay( file, "%m: @ initial_step completed" );
   $fdisplay( file, "M_PI = %3.8f", `M_PI );
   // }}}2

end // initilization }}}1

// every timestep, do ...
Vrme    = V(t1,t2);  // for convenience: rename analog signals to parameter values
Irme    = I(t1,t2);
omega_y = pow( 10, V( log10_omega_y ) );
doReset = 0;

// TIME and LOGGING {{{1
// ========================================================================
// Time(in the simulation, not processor time
timeStep = $abstime - prevTime ;
if( firstStep==1 ) begin
  omega_y = initial_omega_y;
  $fdisplay( file, "omega_y set to initial_omega_y" );
  $fflush( file );
  firstStep=0;
end

//if( timeStep<1e-15 ) begin
//  timeStep=1e-15; // otherwise, we get divide by 0 in spectre
//end

if( $abstime > lastPrintedProgressPoint+progressPrintStep) begin
  $display( "%m: progress: %3.1fns\n", $abstime/1.0e-9 );
  lastPrintedProgressPoint = $abstime;
end

if ( file!=0 ) begin
   $fdisplay( file, "%m: ------ t=%6.6fps ; step =%6.6fps ; Vrme=%3.3fV ; Irme=%gA-------\n", $abstime/1.0e-12, timeStep/1.0e-12, Vrme, Irme  );
end

prevTime = $abstime;
// TIME and LOGGING }}}1

if( !only_QM_IV ) begin
// FORMING {{{1
// ========================================================================
if ( cellFormed<1 && Vrme >= form_V ) begin

    // logging and debug {{{2
    if(file!=0 ) begin
      $fdisplay( file, "%m: ( cellFormed: = /%g )\n", cellFormed );
    end
    if( doBoundTimeStep ) begin
      $bound_step( timestep_programming );
    end // }}}2

    // update cellFormed value [TODO: move to differential equations]
    cellFormed = cellFormed + timeStep * 1/1.0e-9; //tau = 1ns
    if( cellFormed>=1 ) begin
      cellFormed=1.0;
    end

end // forming }}}1

if( cellFormed==1 ) begin

  // SET - UPDATE SET COUNTER -- trigger special set mode {{{1
  if( in_special_set_mode==0 ) begin

    if ( Vrme*Irme>=set_start_power && Vrme>set_hold_V ) begin
      // --> onset requirement to increase set trigger counter is satisfied
      set_trigger_T = calculate_tau( Vrme, set_speed_V_0, set_speed_T_0, set_speed_V_1, set_speed_T_1 );
      set_trigger_counter = set_trigger_counter +  ln(10) * timeStep / set_trigger_T;
          //ln(10) to transform from T_per_decade to T_per_exp(1)
      if(file!=0 ) begin
        $fdisplay( file, "%m: ( set_trigger_T = /%g )\n", set_trigger_T );
        $fdisplay( file, "%m: ( updating set trigger counter )\n" );
      end
    end else begin
      set_trigger_counter=0;
    end

    //did we reach the trigger condition?
    //if yes--> start special set mode
    if( set_trigger_counter>=1 ) begin
      if(file!=0) begin
        $fdisplay( file, "%m: (--------------------------- special set mode started ---------------------)\n" );
      end
      in_special_set_mode=1;
      set_trigger_counter=0;
    end
  end
  // SET 1 }}}1

  // SET: if in special set mode --> adjust omega_y, or drop out if special set mode {{{1
  if( in_special_set_mode==1 ) begin

    // should we exit the special set mode?
    if( Vrme<= (set_hold_V-set_eps_V) ) begin
      in_special_set_mode=0;
      if(file!=0) begin
        $fdisplay( file, "%m: (--------------------------- special set mode exited ---------------------)\n" );
      end
    end else begin
      if( Vrme > set_hold_V ) begin
        // must update omega_y
        // this is done in the differential equations part
      end
    end
  end
  // SET 2}}}1

  // RESET: adjust omega_y if reset conditions are met {{{1
  if( Vrme <= reset_upper_bound_V ) begin
      omega_y_target = calculate_target_omega_y( Vrme, reset_depth_Vreset_0, reset_depth_omega_y_0,
                                                       reset_depth_Vreset_1, reset_depth_omega_y_1 );
      reset_T_per_decade = calculate_tau( Vrme, reset_speed_V_0, reset_speed_T_0,
                                                reset_speed_V_1, reset_speed_T_1 );
      if( omega_y_target > omega_y ) begin
        doReset = 1;
        // omega_y is updated in the differential equations section
      end

      if(file!=0) begin
        $fdisplay( file, "%m: (resetting)\n" );
      end
  end else begin
      omega_y_target=1  ;  // avoid confusing waveform values for visualization, but can't use 0 --> log10 for output...
      reset_T_per_decade=1e9;
  end
  // RESET }}}1

end // end of if(cellFormed==1)

// DIFFERENTIAL EQUATIONS -- cell state {{{1

// MAKE SET SMOOTH: make the adjustment of omega_y afo Vrme versus Vhold smooth rather than 0 | 1 {{{2
V( theta      ) <+ min( `M_PI, max( 0, ( (V(t1,t2)-set_hold_V)/set_smoothing_V ) * `M_PI ) );
if( in_special_set_mode ) begin
  V( doSet_node ) <+   0.5*sin( V(theta) - `M_PI/2 ) +0.5;
end else begin
  V( doSet_node ) <+   0;
end
// }}}2

V( log10_omega_y ) <+ idt( V(doSet_node) * (-1/  set_T_per_decade) +
                           doReset       * ( 1/reset_T_per_decade) * (omega_y_target/omega_y - 1), log( initial_omega_y ) );
// }}}1

end else begin // only_QM_IV
  V( doSet_node ) <+ 0;
  V( log10_omega_y ) <+  log( initial_omega_y );
end

// DRIVE OUTPUT CURRENT
@@ifAnalytical  I(t1, t2) <+ cellFormed * calculateCurrentRME( omega_x, pow(10,V(log10_omega_y)), V0, Vrme, file, 0, Nmax )
@@ifAnalytical             + capacitance * ddt( V(t1,t2) );

@@ifTable  I(t1, t2) <+ $table_model (  pow( 10, V( log10_omega_y ) ), V(t1,t2),  "@@tableFile", "1,1" )
@@ifTable             + capacitance * ddt( V(t1,t2) );

// VISUALIZATION {{{1
if( saveStateSignals ) begin
      V( log10_reset_T_per_decade ) <+ log( reset_T_per_decade );
      V( cellFormed_node          ) <+ cellFormed;
      V( log10_set_trigger_T      ) <+ log( set_trigger_T );
      V( set_trigger_counter_node ) <+ set_trigger_counter ;
      V( log10_omega_y_target     ) <+ log( omega_y_target );
end else begin
      V( log10_reset_T_per_decade ) <+ 33;
      V( cellFormed_node          ) <+ 33;
      V( log10_set_trigger_T      ) <+ 33;
      V( set_trigger_counter_node ) <+ 33;
      V( log10_omega_y_target     ) <+ 33;
end // }}}1

// BOUND TIMESTEP {{{1
if( doBoundTimeStep ) begin
  $bound_step( timestep_normal );
  if( in_special_set_mode==1 || doReset==1 ) begin
    $bound_step( timestep_programming );
  end
  //$discontinuity( 0 );  // announce discontinuity --> avoid that simulator uses (higher order) derivatives
                          // doesn't seem to help
end // }}}1

// CLEANUP AFTER SIMULATIOM {{{1
@( final_step ) begin
  if(file!=0) begin
    $fdisplay( file, "final step - closing file\n" );
    $fclose( file );
  end
end // }}}1

end //analog begin

endmodule
