//A decoder that decodes 4 address bits a0 to a3 into a one-hot output signal S0 ... S15

simulator lang=spectre

// the statement to indicate spectre to write in psfAscii
option1 options rawfmt = psfascii

// {{{1 Transistor Model files

// --- copied from http://www.eas.asu.edu/~ptm/modelcard/2006/90nm_bulk.pm
// no changes made to reflect different threshold voltages
//
//* Beta Version released on 2/22/06
//* PTM 90nm NMOS

// ==============================================================================

model n_10_sp bsim4 type=n
+version = 4.0          binunit = 1            paramchk= 1            mobmod  = 0
+capmod  = 2            igcmod  = 1            igbmod  = 1            geomod  = 1
+diomod  = 1            rdsmod  = 0            rbodymod= 1            rgatemod= 1
+permod  = 1            acnqsmod= 0            trnqsmod= 0
+tnom    = 27           toxe    = 2.05e-9      toxp    = 1.4e-9       toxm    = 2.05e-9
+dtox    = 0.65e-9      epsrox  = 3.9          wint    = 5e-009       lint    = 7.5e-009
+ll      = 0            wl      = 0            lln     = 1            wln     = 1
+lw      = 0            ww      = 0            lwn     = 1            wwn     = 1
+lwl     = 0            wwl     = 0            xpart   = 0            toxref  = 2.05e-9
+xl      = -40e-9
+vth0    = 0.397        k1      = 0.4          k2      = 0.01         k3      = 0
+k3b     = 0            w0      = 2.5e-006     dvt0    = 1            dvt1    = 2
+dvt2    = -0.032       dvt0w   = 0            dvt1w   = 0            dvt2w   = 0
+dsub    = 0.1          minv    = 0.05         voffl   = 0            dvtp0   = 1.2e-009
+dvtp1   = 0.1          lpe0    = 0            lpeb    = 0            xj      = 2.8e-008
+ngate   = 2e+020       ndep    = 1.94e+018    nsd     = 2e+020       phin    = 0
+cdsc    = 0.0002       cdscb   = 0            cdscd   = 0            cit     = 0
+voff    = -0.13        nfactor = 1.7          eta0    = 0.0074       etab    = 0
+vfb     = -0.55        u0      = 0.0547       ua      = 6e-010       ub      = 1.2e-018
+uc      = -3e-011      vsat    = 113760       a0      = 1.0          ags     = 1e-020
+a1      = 0            a2      = 1            b0      = -1e-020      b1      = 0
+keta    = 0.04         dwg     = 0            dwb     = 0            pclm    = 0.06
+pdiblc1 = 0.001        pdiblc2 = 0.001        pdiblcb = -0.005       drout   = 0.5
+pvag    = 1e-020       delta   = 0.01         pscbe1  = 8.14e+008    pscbe2  = 1e-007
+fprout  = 0.2          pdits   = 0.08         pditsd  = 0.23         pditsl  = 2.3e+006
+rsh     = 5            rdsw    = 180          rsw     = 90           rdw     = 90
+rdswmin = 0            rdwmin  = 0            rswmin  = 0            prwg    = 0
+prwb    = 6.8e-011     wr      = 1            alpha0  = 0.074        alpha1  = 0.005
+beta0   = 30           agidl   = 0.0002       bgidl   = 2.1e+009     cgidl   = 0.0002
+egidl   = 0.8
+aigbacc = 0.012        bigbacc = 0.0028       cigbacc = 0.002
+nigbacc = 1            aigbinv = 0.014        bigbinv = 0.004        cigbinv = 0.004
+eigbinv = 1.1          nigbinv = 3            aigc    = 0.012        bigc    = 0.0028
+cigc    = 0.002        aigsd   = 0.012        bigsd   = 0.0028       cigsd   = 0.002
+nigc    = 1            poxedge = 1            pigcd   = 1            ntox    = 1
+xrcrg1  = 12           xrcrg2  = 5
+cgso    = 1.9e-010     cgdo    = 1.9e-010     cgbo    = 2.56e-011    cgdl    = 2.653e-10
+cgsl    = 2.653e-10    ckappas = 0.03         ckappad = 0.03         acde    = 1
+moin    = 15           noff    = 0.9          voffcv  = 0.02
+kt1     = -0.11        kt1l    = 0            kt2     = 0.022        ute     = -1.5
+ua1     = 4.31e-009    ub1     = 7.61e-018    uc1     = -5.6e-011    prt     = 0
+at      = 33000
+fnoimod = 1            tnoimod = 0
+jss     = 0.0001       jsws    = 1e-011       jswgs   = 1e-010       njs     = 1
+ijthsfwd= 0.01         ijthsrev= 0.001        bvs     = 10           xjbvs   = 1
+jsd     = 0.0001       jswd    = 1e-011       jswgd   = 1e-010       njd     = 1
+ijthdfwd= 0.01         ijthdrev= 0.001        bvd     = 10           xjbvd   = 1
+pbs     = 1            cjs     = 0.0005       mjs     = 0.5          pbsws   = 1
+cjsws   = 5e-010       mjsws   = 0.33         pbswgs  = 1            cjswgs  = 3e-010
+mjswgs  = 0.33         pbd     = 1            cjd     = 0.0005       mjd     = 0.5
+pbswd   = 1            cjswd   = 5e-010       mjswd   = 0.33         pbswgd  = 1
+cjswgd  = 5e-010       mjswgd  = 0.33         tpb     = 0.005        tcj     = 0.001
+tpbsw   = 0.005        tcjsw   = 0.001        tpbswg  = 0.005        tcjswg  = 0.001
+xtis    = 3            xtid    = 3
+dmcg    = 0e-006       dmci    = 0e-006       dmdg    = 0e-006       dmcgt   = 0e-007
+dwj     = 0.0e-008     xgw     = 0e-007       xgl     = 0e-008
+rshg    = 0.4          gbmin   = 1e-010       rbpb    = 5            rbpd    = 15
+rbps    = 15           rbdb    = 15           rbsb    = 15           ngcon   = 1

//* PTM 90nm PMOS
model p_10_sp bsim4 type=p
+version = 4.0          binunit = 1            paramchk= 1            mobmod  = 0
+capmod  = 2            igcmod  = 1            igbmod  = 1            geomod  = 1
+diomod  = 1            rdsmod  = 0            rbodymod= 1            rgatemod= 1
+permod  = 1            acnqsmod= 0            trnqsmod= 0
+tnom    = 27           toxe    = 2.15e-009    toxp    = 1.4e-009     toxm    = 2.15e-009
+dtox    = 0.75e-9      epsrox  = 3.9          wint    = 5e-009       lint    = 7.5e-009
+ll      = 0            wl      = 0            lln     = 1            wln     = 1
+lw      = 0            ww      = 0            lwn     = 1            wwn     = 1
+lwl     = 0            wwl     = 0            xpart   = 0            toxref  = 2.15e-009
+xl      = -40e-9
+vth0    = -0.339       k1      = 0.4          k2      = -0.01        k3      = 0
+k3b     = 0            w0      = 2.5e-006     dvt0    = 1            dvt1    = 2
+dvt2    = -0.032       dvt0w   = 0            dvt1w   = 0            dvt2w   = 0
+dsub    = 0.1          minv    = 0.05         voffl   = 0            dvtp0   = 1e-009
+dvtp1   = 0.05         lpe0    = 0            lpeb    = 0            xj      = 2.8e-008
+ngate   = 2e+020       ndep    = 1.43e+018    nsd     = 2e+020       phin    = 0
+cdsc    = 0.000258     cdscb   = 0            cdscd   = 6.1e-008     cit     = 0
+voff    = -0.126       nfactor = 1.7          eta0    = 0.0074       etab    = 0
+vfb     = 0.55         u0      = 0.00711      ua      = 2.0e-009     ub      = 0.5e-018
+uc      = -3e-011      vsat    = 70000        a0      = 1.0          ags     = 1e-020
+a1      = 0            a2      = 1            b0      = 0            b1      = 0
+keta    = -0.047       dwg     = 0            dwb     = 0            pclm    = 0.12
+pdiblc1 = 0.001        pdiblc2 = 0.001        pdiblcb = 3.4e-008     drout   = 0.56
+pvag    = 1e-020       delta   = 0.01         pscbe1  = 8.14e+008    pscbe2  = 9.58e-007
+fprout  = 0.2          pdits   = 0.08         pditsd  = 0.23         pditsl  = 2.3e+006
+rsh     = 5            rdsw    = 200          rsw     = 100          rdw     = 100
+rdswmin = 0            rdwmin  = 0            rswmin  = 0            prwg    = 3.22e-008
+prwb    = 6.8e-011     wr      = 1            alpha0  = 0.074        alpha1  = 0.005
+beta0   = 30           agidl   = 0.0002       bgidl   = 2.1e+009     cgidl   = 0.0002
+egidl   = 0.8
+aigbacc = 0.012        bigbacc = 0.0028       cigbacc = 0.002
+nigbacc = 1            aigbinv = 0.014        bigbinv = 0.004        cigbinv = 0.004
+eigbinv = 1.1          nigbinv = 3            aigc    = 0.69         bigc    = 0.0012
+cigc    = 0.0008       aigsd   = 0.0087       bigsd   = 0.0012       cigsd   = 0.0008
+nigc    = 1            poxedge = 1            pigcd   = 1            ntox    = 1
+xrcrg1  = 12           xrcrg2  = 5
+cgso    = 1.8e-010     cgdo    = 1.8e-010     cgbo    = 2.56e-011    cgdl    = 2.653e-10
+cgsl    = 2.653e-10    ckappas = 0.03         ckappad = 0.03         acde    = 1
+moin    = 15           noff    = 0.9          voffcv  = 0.02
+kt1     = -0.11        kt1l    = 0            kt2     = 0.022        ute     = -1.5
+ua1     = 4.31e-009    ub1     = 7.61e-018    uc1     = -5.6e-011    prt     = 0
+at      = 33000
+fnoimod = 1            tnoimod = 0
+jss     = 0.0001       jsws    = 1e-011       jswgs   = 1e-010       njs     = 1
+ijthsfwd= 0.01         ijthsrev= 0.001        bvs     = 10           xjbvs   = 1
+jsd     = 0.0001       jswd    = 1e-011       jswgd   = 1e-010       njd     = 1
+ijthdfwd= 0.01         ijthdrev= 0.001        bvd     = 10           xjbvd   = 1
+pbs     = 1            cjs     = 0.0005       mjs     = 0.5          pbsws   = 1
+cjsws   = 5e-010       mjsws   = 0.33         pbswgs  = 1            cjswgs  = 3e-010
+mjswgs  = 0.33         pbd     = 1            cjd     = 0.0005       mjd     = 0.5
+pbswd   = 1            cjswd   = 5e-010       mjswd   = 0.33         pbswgd  = 1
+cjswgd  = 5e-010       mjswgd  = 0.33         tpb     = 0.005        tcj     = 0.001
+tpbsw   = 0.005        tcjsw   = 0.001        tpbswg  = 0.005        tcjswg  = 0.001
+xtis    = 3            xtid    = 3
+dmcg    = 0e-006       dmci    = 0e-006       dmdg    = 0e-006       dmcgt   = 0e-007
+dwj     = 0.0e-008     xgw     = 0e-007       xgl     = 0e-008
+rshg    = 0.4          gbmin   = 1e-010       rbpb    = 5            rbpd    = 15
+rbps    = 15           rbdb    = 15           rbsb    = 15           ngcon   = 1
// }}}1

parameters width=120n
parameters length=80n

// BASIC gates {{{1
// =========================================================================
// INVERTOR  {{{2
// --------------------------------
subckt INVERTOR (  vdd vss vddBulk vssBulk  in   out  )
parameters S=0 pnratio=2

mUp   ( vdd in out vddBulk ) p_10_sp w=width*S*pnratio    l=length
mDown ( vss in out vssBulk ) n_10_sp w=width*S            l=length

ends INVERTOR
// }}}2

// NAND  {{{2
// --------------------------------
subckt NAND (  vdd vss vddBulk vssBulk  in1 in2  out  )
parameters S=0

mUp1   ( vdd in1 out vddBulk ) p_10_sp w=width*S  l=length
mUp2   ( vdd in2 out vddBulk ) p_10_sp w=width*S  l=length
mDown1 ( n1  in1 out vssBulk ) n_10_sp w=width*S  l=length
mDown2 ( vss in2 n1  vssBulk ) n_10_sp w=width*S  l=length

ends NAND
// }}}2

// AND  {{{2
// --------------------------------
subckt AND (  vdd vss vddBulk vssBulk  in1 in2  out  )
parameters Sinv=0 Snand=0

Xnand ( vdd vss vddBulk vssBulk  in1 in2 outBar )  NAND     S=Snand
Xinv  ( vdd vss vddBulk vssBulk  outBar  out    )  INVERTOR S=Sinv

ends AND
// }}}2

// }}}1

// DECODER {{{1
// =========================================================================
//
// PREDECODER_2_4  {{{2
// --------------------------------
subckt PREDECODER_2_4 (  vdd vss vddBulk vssBulk  a0   a1  N_0 N_1 N_2 N_3  )

Xinv_0 ( vdd vss vddBulk vssBulk   a0 a0Bar ) INVERTOR S=2
Xinv_1 ( vdd vss vddBulk vssBulk   a1 a1Bar ) INVERTOR S=2

Xnand_0 ( vdd vss vddBulk vssBulk  a0Bar a1Bar   N_0 ) AND Sinv=2 Snand=2
Xnand_1 ( vdd vss vddBulk vssBulk  a0    a1Bar   N_1 ) AND Sinv=2 Snand=2
Xnand_2 ( vdd vss vddBulk vssBulk  a0Bar a1      N_2 ) AND Sinv=2 Snand=2
Xnand_3 ( vdd vss vddBulk vssBulk  a0    a1      N_3 ) AND Sinv=2 Snand=2

ends PREDECODER_2_4
// }}}2

// DECODER_4_16  {{{2
// --------------------------------
subckt DECODER_4_16 (  vdd vss vddBulk vssBulk
+                      a0 a1 a2 a3
+                      S_0 S_1 S_2 S_3 S_4 S_5 S_6 S_7 S_8 S_9 S_10 S_11 S_12 S_13 S_14 S_15  )

Xpre_A ( vdd vss vddBulk vssBulk a0 a1 A_0 A_1 A_2 A_3 ) PREDECODER_2_4
Xpre_B ( vdd vss vddBulk vssBulk a2 a3 B_0 B_1 B_2 B_3 ) PREDECODER_2_4

Xand_0_0 ( vdd vss vddBulk vssBulk A_0 B_0 S_0 ) AND Sinv=2 Snand=2
Xand_1_0 ( vdd vss vddBulk vssBulk A_1 B_0 S_1 ) AND Sinv=2 Snand=2
Xand_2_0 ( vdd vss vddBulk vssBulk A_2 B_0 S_2 ) AND Sinv=2 Snand=2
Xand_3_0 ( vdd vss vddBulk vssBulk A_3 B_0 S_3 ) AND Sinv=2 Snand=2
Xand_0_1 ( vdd vss vddBulk vssBulk A_0 B_1 S_4 ) AND Sinv=2 Snand=2
Xand_1_1 ( vdd vss vddBulk vssBulk A_1 B_1 S_5 ) AND Sinv=2 Snand=2
Xand_2_1 ( vdd vss vddBulk vssBulk A_2 B_1 S_6 ) AND Sinv=2 Snand=2
Xand_3_1 ( vdd vss vddBulk vssBulk A_3 B_1 S_7 ) AND Sinv=2 Snand=2
Xand_0_2 ( vdd vss vddBulk vssBulk A_0 B_2 S_8 ) AND Sinv=2 Snand=2
Xand_1_2 ( vdd vss vddBulk vssBulk A_1 B_2 S_9 ) AND Sinv=2 Snand=2
Xand_2_2 ( vdd vss vddBulk vssBulk A_2 B_2 S_10 ) AND Sinv=2 Snand=2
Xand_3_2 ( vdd vss vddBulk vssBulk A_3 B_2 S_11 ) AND Sinv=2 Snand=2
Xand_0_3 ( vdd vss vddBulk vssBulk A_0 B_3 S_12 ) AND Sinv=2 Snand=2
Xand_1_3 ( vdd vss vddBulk vssBulk A_1 B_3 S_13 ) AND Sinv=2 Snand=2
Xand_2_3 ( vdd vss vddBulk vssBulk A_2 B_3 S_14 ) AND Sinv=2 Snand=2
Xand_3_3 ( vdd vss vddBulk vssBulk A_3 B_3 S_15 ) AND Sinv=2 Snand=2

ends DECODER_4_16
// }}}2

// }}}1

Xdecoder  (  vdd vss vddBulk vssBulk
+            a0 a1 a2 a3
+            S_0 S_1 S_2 S_3 S_4 S_5 S_6 S_7 S_8 S_9 S_10 S_11 S_12 S_13 S_14 S_15  ) DECODER_4_16

parameters dummy = 0

//mysweep sweep param=dummy start=0 step=1 stop=100 {
  tran1 tran start=0p stop=20n
//}

VvddBulk ( vddBulk   0 ) vsource type=dc dc=1
VvssBulk ( vssBulk   0 ) vsource type=dc dc=0
Vvdd ( vdd   0 ) vsource type=dc dc=1
Vvss ( vss   0 ) vsource type=dc dc=0

Va0 ( a0 0 ) vsource type=pwl
+ wave=[
+ 0 0   9.5e-10 0  1e-09 1.2
+ 1.95e-09 1.2   2e-09 0
+ 2.95e-09 0   3e-09 1.2
+ 3.95e-09 1.2   4e-09 0
+ 4.95e-09 0   5e-09 1.2
+ 5.95e-09 1.2   6e-09 0
+ 6.95e-09 0   7e-09 1.2
+ 7.95e-09 1.2   8e-09 0
+ 8.95e-09 0   9e-09 1.2
+ 9.95e-09 1.2   1e-08 0
+ 1.095e-08 0   1.1e-08 1.2
+ 1.195e-08 1.2   1.2e-08 0
+ 1.295e-08 0   1.3e-08 1.2
+ 1.395e-08 1.2   1.4e-08 0
+ 1.495e-08 0   1.5e-08 1.2
+ 1.595e-08 1.2   1.6e-08 0
+ 1.695e-08 0   1.7e-08 1.2
+ ]

Va1 ( a1 0 ) vsource type=pwl
+ wave=[
+ 0 0   9.5e-10 0  1e-09 0
+ 1.95e-09 0   2e-09 1.2
+ 2.95e-09 1.2   3e-09 1.2
+ 3.95e-09 1.2   4e-09 0
+ 4.95e-09 0   5e-09 0
+ 5.95e-09 0   6e-09 1.2
+ 6.95e-09 1.2   7e-09 1.2
+ 7.95e-09 1.2   8e-09 0
+ 8.95e-09 0   9e-09 0
+ 9.95e-09 0   1e-08 1.2
+ 1.095e-08 1.2   1.1e-08 1.2
+ 1.195e-08 1.2   1.2e-08 0
+ 1.295e-08 0   1.3e-08 0
+ 1.395e-08 0   1.4e-08 1.2
+ 1.495e-08 1.2   1.5e-08 1.2
+ 1.595e-08 1.2   1.6e-08 0
+ 1.695e-08 0   1.7e-08 0
+ ]

Va2 ( a2 0 ) vsource type=pwl
+ wave=[
+ 0 0   9.5e-10 0  1e-09 0
+ 1.95e-09 0   2e-09 0
+ 2.95e-09 0   3e-09 0
+ 3.95e-09 0   4e-09 1.2
+ 4.95e-09 1.2   5e-09 1.2
+ 5.95e-09 1.2   6e-09 1.2
+ 6.95e-09 1.2   7e-09 1.2
+ 7.95e-09 1.2   8e-09 0
+ 8.95e-09 0   9e-09 0
+ 9.95e-09 0   1e-08 0
+ 1.095e-08 0   1.1e-08 0
+ 1.195e-08 0   1.2e-08 1.2
+ 1.295e-08 1.2   1.3e-08 1.2
+ 1.395e-08 1.2   1.4e-08 1.2
+ 1.495e-08 1.2   1.5e-08 1.2
+ 1.595e-08 1.2   1.6e-08 0
+ 1.695e-08 0   1.7e-08 0
+ ]

Va3 ( a3 0 ) vsource type=pwl
+ wave=[
+ 0 0   9.5e-10 0  1e-09 0
+ 1.95e-09 0   2e-09 0
+ 2.95e-09 0   3e-09 0
+ 3.95e-09 0   4e-09 0
+ 4.95e-09 0   5e-09 0
+ 5.95e-09 0   6e-09 0
+ 6.95e-09 0   7e-09 0
+ 7.95e-09 0   8e-09 1.2
+ 8.95e-09 1.2   9e-09 1.2
+ 9.95e-09 1.2   1e-08 1.2
+ 1.095e-08 1.2   1.1e-08 1.2
+ 1.195e-08 1.2   1.2e-08 1.2
+ 1.295e-08 1.2   1.3e-08 1.2
+ 1.395e-08 1.2   1.4e-08 1.2
+ 1.495e-08 1.2   1.5e-08 1.2
+ 1.595e-08 1.2   1.6e-08 0
+ 1.695e-08 0   1.7e-08 0
+ ]
