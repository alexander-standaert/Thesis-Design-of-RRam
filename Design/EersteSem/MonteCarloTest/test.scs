// showcase for mismatch simulation

simulator lang=spectre

include "transistorsPTM.scs"
include "latch.scs"
include "memarray.scs"
include "parameters.sp"

// enableMismatch is used in transistorsPTM.
// Put to 0 to disable mismatch
// use transistor instance parameters shiftVt and shiftBeta to perform
// worst-case analysis
parameters enableMismatch=1

parameters PWmin = 100n
parameters PLmin = 45n

xLatch inout inoutbar vdd vss bp bn latchEnableP latchEnableN latch
xMemArray bl_1 bl_ref sel1_1 sel1_2 sel1_3 sel2_1 sel2_2 sel2_3 wl_1 wl_2 wl_3 vdd vss bp bn memarray
xSwitch1 bl_1 switch1 inout bn mc_nmos_lvt w=PWmin l=PLmin
xSwitch2 bl_ref switch2 inoutbar bn mc_nmos_lvt w=PWmin l=PLmin

Vvdd     ( vdd     0 ) vsource dc=1
VvddBulk ( bp 0 ) vsource dc=1
Vvss     ( vss     0 ) vsource dc=0
VvssBulk ( bn 0 ) vsource dc=0

Vsel1_1 (sel1_1 0) vsource type=pwl wave=sel1_1wave
Vsel1_2 (sel1_2 0) vsource type=pwl wave=sel1_2wave
Vsel1_3 (sel1_3 0) vsource type=pwl wave=sel1_3wave
Vsel2_1 (sel2_1 0) vsource type=pwl wave=sel2_1wave
Vsel2_2 (sel1_2 2) vsource type=pwl wave=sel2_2wave
Vsel2_3 (sel2_3 0) vsource type=pwl wave=sel2_3wave
Vwl_1 (wl_1 0) vsource type=pwl wave=wl_1wave
Vwl_2 (wl_2 0) vsource type=pwl wave=wl_2wave
Vwl_3 (wl_3 0) vsource type=pwl wave=wl_3wave
Vswitch1 (switch1 0) vsource type=pwl wave=switch1wave
Vswitch2 (switch2 0) vsource type=pwl wave=switch2wave
Vlep (latchEnableP 0) vsource type=pwl wave=lepwave
Vlen (latchEnableN 0) vsource type=pwl wave=lenwave

ic inout = 0
ic inoutbar = 0

//myOpt options rawfmt=psfascii
//save *
//save current all

mymc montecarlo
+ donominal=no variations=mismatch
+ seed=1234
+ numruns=numberofruns
+ firstrun=1
+ saveprocessparams=yes
+ savefamilyplots= yes {
mytran tran stop=10n
}
option1 options rawfmt = psfascii
