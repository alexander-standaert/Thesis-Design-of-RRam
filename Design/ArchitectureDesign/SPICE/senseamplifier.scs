subckt senseamplifier (vdd vss nbulk pbulk inout inoutbar enablep enablen)

xM1 inout inoutbar n1 pbulk mc_pmos_hvt w=PWp l=PLmin
xM2 inoutbar inout n1 pbulk mc_pmos_hvt w=PWp l=PLmin
xM3 inout inoutbar n2 nbulk mc_nmos_hvt w=PWn l=PLmin
xM4 inoutbar inout n2 nbulk mc_nmos_hvt w=PWn l=PLmin

xM5 n1 enablep vdd pbulk mc_pmos_hvt w=PWpenable l=PLmin
xM6 n2 enablen vss nbulk mc_nmos_hvt w=PWnenable l=PLmin

ends senseamplifier
