subckt load (LoadLine Bitline PBulkLine)

xM Bitline gate LoadLine PBulkLine mc_pmos_lvt w=WBias l=PLmin
Vg gate 0 vsource dc=0

ends load
