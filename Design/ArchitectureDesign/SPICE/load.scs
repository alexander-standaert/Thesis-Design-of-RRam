subckt load (LoadLine BitLine PBulkLine)

rLoad (LoadLine BitLine) resistor r=0;

ends load
