// "mismatch models for spectre"
// wrapper circuits to enable MC simulation of transistor mismatch

// Pelgrom constants ( change these random values with real technology data )
// ( these values express the difference in Vt / Ion between two transistors )
parameters AdVt_n = 2.82    // mV*um
parameters AdVt_p = 2.5    // mV*um

parameters AdI_I0_n = 2     // %*um
parameters AdI_I0_p = 1.2   // %*um

// the standard deviation to be used
// naked distribution is for a 1u*1u transistor
parameters sigma_LVT_Vt_n   = (( AdVt_n   /1000)/sqrt(2))*sqrt(1u*1u)
parameters sigma_LVT_Vt_p   = (( AdVt_p   /1000)/sqrt(2))*sqrt(1u*1u)
parameters sigma_LVT_I_I0_n = (( AdI_I0_n /100 )/sqrt(2))*sqrt(1u*1u)
parameters sigma_LVT_I_I0_p = (( AdI_I0_p /100 )/sqrt(2))*sqrt(1u*1u)

// these parameters get a new randomly selected value for each instance,
// independently selected from the appropriate distribution
parameters delta_1um_LVT_Vt_n=0
parameters delta_1um_LVT_Vt_p=0
parameters delta_1um_LVT_I_I0_n=0
parameters delta_1um_LVT_I_I0_p=0

statistics {
  mismatch{
    vary delta_1um_LVT_Vt_n   dist=gauss std=sigma_LVT_Vt_n
    vary delta_1um_LVT_Vt_p   dist=gauss std=sigma_LVT_Vt_p
    vary delta_1um_LVT_I_I0_n dist=gauss std=sigma_LVT_I_I0_n
    vary delta_1um_LVT_I_I0_p dist=gauss std=sigma_LVT_I_I0_p
  }
}

subckt mc_nmos_lvt ( d g s b )
parameters
+ controlledOffset = 0
+ enableVtMismatch = 1
+ enableBetaMismatch = 1
+ sigmamult = 1
+ mismatchVt=1 *enableVtMismatch
+ mismatchBeta=0 * enableBetaMismatch
+ shiftVt= sigma_LVT_Vt_n*controlledOffset
+ shiftBeta= sigma_LVT_I_I0_n*controlledOffset
+ w=100e-9
+ l=45e-9
+ beta_factor = sigmamult*mismatchBeta*(( delta_1um_LVT_I_I0_n / sqrt(w*l)*enableMismatch ) + shiftBeta/sqrt(w*l))
+ vt_factor   = sigmamult*mismatchVt*(( delta_1um_LVT_Vt_n   / sqrt(w*l) )*enableMismatch + shiftVt/sqrt(w*l))

v_model_Vth_mismatch ( g rg ) vsource type=dc dc=vt_factor
i_model_beta_mismatch ( d s ) cccs probe=probe1 gain=beta_factor

mnmos ( d rg rs b ) nmos l=l w=w
probe1 ( rs s ) iprobe

ends mc_nmos_lvt

subckt mc_pmos_lvt ( d g s b )
parameters
+ controlledOffset = 0
+ enableVtMismatch = 1
+ enableBetaMismatch = 1
+ sigmamult = 1
+ mismatchVt=1 * enableVtMismatch
+ mismatchBeta=0 * enableBetaMismatch
+ shiftVt= sigma_LVT_Vt_p*controlledOffset
+ shiftBeta= sigma_LVT_I_I0_p*controlledOffset
+ w=100e-9
+ l=45e-9
+ beta_factor = sigmamult*mismatchBeta*(( delta_1um_LVT_I_I0_p / sqrt(w*l) )*enableMismatch + shiftBeta/sqrt(w*l))
+ vt_factor   = sigmamult*mismatchVt*(( delta_1um_LVT_Vt_p   / sqrt(w*l) )*enableMismatch + shiftVt/sqrt(w*l))

v_model_Vth_mismatch ( g rg ) vsource type=dc dc=vt_factor
i_model_beta_mismatch ( d s ) cccs probe=probe1 gain=beta_factor

mpmos ( d rg rs b ) pmos l=l w=w
probe1 ( rs s ) iprobe

ends mc_pmos_lvt

subckt mc_nmos_hvt ( d g s b )
parameters
+ controlledOffset = 0
+ enableVtMismatch = 1
+ enableBetaMismatch = 1
+ sigmamult = 1
+ mismatchVt=1 * enableVtMismatch
+ mismatchBeta=0 * enableBetaMismatch
+ shiftVt= sigma_LVT_Vt_n*controlledOffset
+ shiftBeta= sigma_LVT_I_I0_n*controlledOffset
+ w=100e-9
+ l=45e-9
+ beta_factor = sigmamult*mismatchBeta*(( delta_1um_LVT_I_I0_n / sqrt(w*l) )*enableMismatch + shiftBeta/sqrt(w*l))
+ vt_factor   = sigmamult*mismatchVt*(( delta_1um_LVT_Vt_n   / sqrt(w*l) )*enableMismatch + shiftVt/sqrt(w*l))

v_model_Vth_mismatch ( g rg ) vsource type=dc dc=vt_factor
i_model_beta_mismatch ( d s ) cccs probe=probe1 gain=beta_factor

mnmos ( d rg rs b ) mosn_h l=l w=w
probe1 ( rs s ) iprobe

ends mc_nmos_hvt

subckt mc_pmos_hvt ( d g s b )
parameters
+ controlledOffset = 0
+ enableVtMismatch = 1
+ enableBetaMismatch = 1
+ sigmamult = 1
+ mismatchVt=1 * enableVtMismatch
+ mismatchBeta=0 * enableBetaMismatch
+ shiftVt= sigma_LVT_Vt_p*controlledOffset
+ shiftBeta= sigma_LVT_I_I0_p*controlledOffset
+ w=100e-9
+ l=45e-9
+ beta_factor = sigmamult*mismatchBeta*(( delta_1um_LVT_I_I0_p / sqrt(w*l) )*enableMismatch + shiftBeta/sqrt(w*l))
+ vt_factor   = sigmamult*mismatchVt*(( delta_1um_LVT_Vt_p   / sqrt(w*l) )*enableMismatch + shiftVt/sqrt(w*l))

v_model_Vth_mismatch ( g rg ) vsource type=dc dc=vt_factor
i_model_beta_mismatch ( d s ) cccs probe=probe1 gain=beta_factor

mpmos ( d rg rs b ) mosp_h l=l w=w
probe1 ( rs s ) iprobe

ends mc_pmos_hvt

subckt mc_pmos_m ( d g s b)
parameters
+ mismatchVt=1 * enableMismatch
+ mismatchBeta=1 * enableMismatch
+ shiftVt=0
+ shiftBeta=0
+ w=100e-9
+ l=45e-9
+ beta_factor = ( delta_Ip /sqrt(w*l) ) * mismatchBeta + shiftBeta
+ vt_factor   = ( delta_Vp / sqrt(w*l) ) * mismatchVt + shiftVt

v_model_Vth_mismatch ( g rg ) vsource type=dc dc=vt_factor
i_model_beta_mismatch ( d s ) cccs probe=probe1 gain=beta_factor

mpmos ( d rg rs b ) pmos l=l w=w
probe1 ( rs s ) iprobe

ends mc_pmos_m

subckt mc_pmos_mm ( d g s b)
parameters
+ mismatchVt=1 * enableMismatch
+ mismatchBeta=1 * enableMismatch
+ shiftVt=0
+ shiftBeta=0
+ w=100e-9
+ l=45e-9
+ beta_factor = ( delta_Ipm /sqrt(w*l) ) * mismatchBeta + shiftBeta
+ vt_factor   = ( delta_Vpm / sqrt(w*l) ) * mismatchVt + shiftVt

v_model_Vth_mismatch ( g rg ) vsource type=dc dc=vt_factor
i_model_beta_mismatch ( d s ) cccs probe=probe1 gain=beta_factor

mpmos ( d rg rs b ) pmos l=l w=w
probe1 ( rs s ) iprobe

ends mc_pmos_mm
