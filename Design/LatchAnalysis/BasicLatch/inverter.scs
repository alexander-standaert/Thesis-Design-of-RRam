subckt inverter (in out vdd vss bp bn)
parameters PWinvp = 200n PWinvn = 100n

xM1 out in vdd bp mc_pmos_lvt w=PWinvp l=PLmin
xM2 out in vss bn mc_nmos_lvt w=PWinvn l=PLmin

ends inverter
