subckt latch (out outbar vdd vss bp bn latchenablep latchenablen)

xM1 out outbar n1 bp mc_pmos_hvt w=PWp l=PLmin
xM2 outbar out n1 bp mc_pmos_hvt w=PWp l=PLmin
xM3 out outbar n2 bn mc_nmos_hvt w=PWn l=PLmin
xM4 outbar out n2 bn mc_nmos_hvt w=PWn l=PLmin

xM5 n1 latchenablep vdd bp mc_pmos_hvt w=PWpenable l=PLmin
xM6 n2 latchenablen vss bn mc_nmos_hvt w=PWnenable l=PLmin

ends latch
