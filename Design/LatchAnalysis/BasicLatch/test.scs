// showcase for mismatch simulation

simulator lang=spice
.lib '../../ArchitectureDesign/SPICE/tech_wrapper.lib' tt

simulator lang=spectre

include "../../ArchitectureDesign/SPICE/monte_carlo_models.scs"
include "latch.scs"
include "inverter.scs"
include "parameters.sp"

// enableMismatch is used in transistorsPTM.
// Put to 0 to disable mismatch
// use transistor instance parameters shiftVt and shiftBeta to perform
// worst-case analysis
parameters enableMismatch=1

parameters PWmin = 100n
parameters PLmin = 45n

xLatch inout inoutbar vdd vss bp bn latchEnableP latchEnableN latch
//xInv1 inout whatevs vdd2 vss bp bn inverter PWinvp=200n PWinvn=100n
//XInv2 inoutbar whatevs2 vdd2 vss bp bn inverter PWinvp=300n PWinvn=150n

Vvdd     ( vdd     0 ) vsource dc=1
Vvdd2    (vdd2      0) vsource dc=1
VvddBulk ( bp 0 ) vsource dc=1
Vvss     ( vss     0 ) vsource dc=0
VvssBulk ( bn 0 ) vsource dc=0

Vlep (latchEnableP 0) vsource type=pwl wave=lepwave
Vlen (latchEnableN 0) vsource type=pwl wave=lenwave

ic inout = initialout
ic inoutbar = initialoutbar

//myOpt options rawfmt=psfascii
//save *
//save current all

mymc montecarlo
+ donominal=no variations=mismatch
+ seed=1234
+ numruns=numberofruns
+ firstrun=1
+ saveprocessparams=yes
+ savefamilyplots= yes {
mytran tran stop=3n
}
option1 options rawfmt = psfascii
