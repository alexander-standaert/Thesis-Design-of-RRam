subckt inverter (in out vdd vss bp bn)

xM1 out in vdd bp mc_pmos_lvt w=PWmin l=PLmin
xM2 out in vss bn mc_nmos_lvt w=PWmin l=PLmin

ends inverter

subckt 2nand (A B out vdd vss bp bn)

xM1 out A vdd bp mc_pmos_lvt w=PWmin l=PLmin
xM2 out B vdd bp mc_pmos_lvt w=PWmin l=PLmin
xM3 n A vss bn mc_nmos_lvt w=PWmin l=PLmin
xM4 out B n bn mc_nmos_lvt w=PWmin l=PLmin

ends 2nand

subckt 2nor (A B out vdd vss bp bn)

xM1 n A vdd bp mc_pmos_lvt w=PWmin l=PLmin
xM2 out B n bp mc_pmos_lvt w=PWmin l=PLmin
xM3 out A vss bn mc_nmos_lvt w=PWmin l=PLmin
xM4 out B vss bn mc_nmos_lvt w=PWmin l=PLmin

ends 2nor

subckt 3nand (A B C out vdd vss bp bn)

xM1 out A vdd bp mc_pmos_lvt w=PWmin l=PLmin
xM2 out B vdd bp mc_pmos_lvt w=PWmin l=PLmin
xM3 out C vdd bp mc_pmos_lvt w=PWmin l=PLmin
xM4 n1 A vss bn mc_nmos_lvt w=PWmin l=PLmin
xM5 n2 B n1 bn mc_nmos_lvt w=PWmin l=PLmin
xM6 out B n2 bn mc_nmos_lvt w=PWmin l=PLmin

ends 3nand

subckt 3nor (A B C out vdd vss bp bn)

xM1 n1 A vdd bp mc_pmos_lvt w=PWmin l=PLmin
xM2 n2 B n1 bp mc_pmos_lvt w=PWmin l=PLmin
xM3 out C n2 bp mc_pmos_lvt w=PWmin l=PLmin
xM4 out A vss bn mc_nmos_lvt w=PWmin l=PLmin
xM5 out B vss bn mc_nmos_lvt w=PWmin l=PLmin
xM6 out B vss bn mc_nmos_lvt w=PWmin l=PLmin

ends 3nor

subckt 2to4decoder (a0 a1 enablebar N0 N1 N2 N3 vdd vss bp bn)

xinv1 a0 a0bar vdd vss bp bn inverter
xinv2 a1 a1bar vdd vss bp bn inverter

xnand1 a0bar a1bar N0pre vdd vss bp bn 2nand
xnand2 a0bar a1 N1pre vdd vss bp bn 2nand
xnand3 a0 a1bar N2pre vdd vss bp bn 2nand
xnand4 a0 a1 N3pre vdd vss bp bn 2nand

xnor1 N0pre enablebar N0 vdd vss bp bn 2nor
xnor2 N1pre enablebar N1 vdd vss bp bn 2nor
xnor3 N2pre enablebar N2 vdd vss bp bn 2nor
xnor4 N3pre enablebar N3 vdd vss bp bn 2nor

ends 2to4decoder

subckt 3to8decoder (a0 a1 a2 enablebar N0 N1 N2 N3 N4 N5 N6 N7 vdd vss bp bn)

xinv1 a0 a0bar vdd vss bp bn inverter
xinv2 a1 a1bar vdd vss bp bn inverter
xinv3 a2 a2bar vdd vss bp bn inverter

xnand1 a0bar a1bar a2bar N0pre vdd vss bp bn 3nand
xnand2 a0 a1bar a2bar N1pre vdd vss bp bn 3nand
xnand3 a0bar a1 a2bar N2pre vdd vss bp bn 3nand
xnand4 a0 a1 a2bar N3pre vdd vss bp bn 3nand
xnand5 a0bar a1bar a2 N4pre vdd vss bp bn 3nand
xnand6 a0 a1bar a2 N5pre vdd vss bp bn 3nand
xnand7 a0bar a1 a2 N6pre vdd vss bp bn 3nand
xnand8 a0 a1 a2 N7pre vdd vss bp bn 3nand

xnor1 N0pre enablebar N0 vdd vss bp bn 2nor
xnor2 N1pre enablebar N1 vdd vss bp bn 2nor
xnor3 N2pre enablebar N2 vdd vss bp bn 2nor
xnor4 N3pre enablebar N3 vdd vss bp bn 2nor
xnor5 N4pre enablebar N4 vdd vss bp bn 2nor
xnor6 N5pre enablebar N5 vdd vss bp bn 2nor
xnor7 N6pre enablebar N6 vdd vss bp bn 2nor
xnor8 N7pre enablebar N7 vdd vss bp bn 2nor

ends 3to8decoder
